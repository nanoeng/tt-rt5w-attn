** sch_path: /home/claude/rt5w_sky/tt/xschem/rt5w_keycell.sch
.subckt rt5w_keycell dcol w vw wsel vbn row vdd vss
*.iopin dcol
*.ipin w
*.iopin vw
*.ipin wsel
*.ipin vbn
*.iopin row
XMp1 nl nl vdd vdd sky130_fd_pr__pfet_g5v0d10v5 L=4 W=4.14 nf=1 ad=1.201 as=1.201 pd=8.86 ps=8.86 nrd=0.07005 nrs=0.07005 sa=0
+ sb=0 sd=0 mult=2 m=2
XMp2 g nl vdd vdd sky130_fd_pr__pfet_g5v0d10v5 L=4 W=4.14 nf=1 ad=1.201 as=1.201 pd=8.86 ps=8.86 nrd=0.07005 nrs=0.07005 sa=0 sb=0
+ sd=0 mult=2 m=2
XM1 nl dcol ta vss sky130_fd_pr__nfet_g5v0d10v5 L=4 W=0.62 nf=1 ad=0.1798 as=0.1798 pd=1.82 ps=1.82 nrd=0.4677 nrs=0.4677 sa=0
+ sb=0 sd=0 mult=1 m=1
XM2 g g ta vss sky130_fd_pr__nfet_g5v0d10v5 L=4 W=0.62 nf=1 ad=0.1798 as=0.1798 pd=1.82 ps=1.82 nrd=0.4677 nrs=0.4677 sa=0 sb=0
+ sd=0 mult=1 m=1
XM3 nl h tb vss sky130_fd_pr__nfet_g5v0d10v5 L=4 W=0.62 nf=1 ad=0.1798 as=0.1798 pd=1.82 ps=1.82 nrd=0.4677 nrs=0.4677 sa=0 sb=0
+ sd=0 mult=1 m=1
XM4 g w tb vss sky130_fd_pr__nfet_g5v0d10v5 L=4 W=0.62 nf=1 ad=0.1798 as=0.1798 pd=1.82 ps=1.82 nrd=0.4677 nrs=0.4677 sa=0 sb=0
+ sd=0 mult=1 m=1
XMt1 ta vbn vss vss sky130_fd_pr__nfet_g5v0d10v5 L=4 W=2.24 nf=1 ad=0.6496 as=0.6496 pd=5.06 ps=5.06 nrd=0.1295 nrs=0.1295 sa=0
+ sb=0 sd=0 mult=1 m=1
XMt2 tb vbn vss vss sky130_fd_pr__nfet_g5v0d10v5 L=4 W=2.24 nf=1 ad=0.6496 as=0.6496 pd=5.06 ps=5.06 nrd=0.1295 nrs=0.1295 sa=0
+ sb=0 sd=0 mult=1 m=1
XMc row g vdd vdd sky130_fd_pr__pfet_g5v0d10v5 L=4 W=8.27 nf=1 ad=2.398 as=2.398 pd=17.12 ps=17.12 nrd=0.03507 nrs=0.03507 sa=0
+ sb=0 sd=0 mult=1 m=1
XCw vss h vss vss sky130_fd_pr__nfet_g5v0d10v5 L=10.4 W=10.4 nf=1 ad=3.016 as=3.016 pd=21.38 ps=21.38 nrd=0.02788 nrs=0.02788 sa=0
+ sb=0 sd=0 mult=1 m=1
XMwn h wsel vw vss sky130_fd_pr__nfet_g5v0d10v5 L=0.5 W=0.84 nf=1 ad=0.2436 as=0.2436 pd=2.26 ps=2.26 nrd=0.3452 nrs=0.3452 sa=0
+ sb=0 sd=0 mult=1 m=1
XMwp h wselb vw vdd sky130_fd_pr__pfet_g5v0d10v5 L=0.5 W=0.84 nf=1 ad=0.2436 as=0.2436 pd=2.26 ps=2.26 nrd=0.3452 nrs=0.3452 sa=0
+ sb=0 sd=0 mult=1 m=1
XMip wselb wsel vdd vdd sky130_fd_pr__pfet_g5v0d10v5 L=0.5 W=0.84 nf=1 ad=0.2436 as=0.2436 pd=2.26 ps=2.26 nrd=0.3452 nrs=0.3452
+ sa=0 sb=0 sd=0 mult=1 m=1
XMin wselb wsel vss vss sky130_fd_pr__nfet_g5v0d10v5 L=0.5 W=0.84 nf=1 ad=0.2436 as=0.2436 pd=2.26 ps=2.26 nrd=0.3452 nrs=0.3452
+ sa=0 sb=0 sd=0 mult=1 m=1
.ends
.GLOBAL vdd
.GLOBAL vss
.end
