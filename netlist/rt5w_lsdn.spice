** sch_path: /home/claude/rt5w_sky/tt/xschem/rt5w_lsdn.sch
.subckt rt5w_lsdn in out vddl vss
*.ipin in
*.opin out
*.iopin vddl
XMap mid in vddl vddl sky130_fd_pr__pfet_g5v0d10v5 L=0.5 W=1.68 nf=1 ad=0.4872 as=0.4872 pd=3.94 ps=3.94 nrd=0.1726 nrs=0.1726
+ sa=0 sb=0 sd=0 mult=1 m=1
XMan mid in vss vss sky130_fd_pr__nfet_g5v0d10v5 L=0.5 W=0.84 nf=1 ad=0.2436 as=0.2436 pd=2.26 ps=2.26 nrd=0.3452 nrs=0.3452 sa=0
+ sb=0 sd=0 mult=1 m=1
XMbp out mid vddl vddl sky130_fd_pr__pfet_g5v0d10v5 L=0.5 W=1.68 nf=1 ad=0.4872 as=0.4872 pd=3.94 ps=3.94 nrd=0.1726 nrs=0.1726
+ sa=0 sb=0 sd=0 mult=1 m=1
XMbn out mid vss vss sky130_fd_pr__nfet_g5v0d10v5 L=0.5 W=0.84 nf=1 ad=0.2436 as=0.2436 pd=2.26 ps=2.26 nrd=0.3452 nrs=0.3452 sa=0
+ sb=0 sd=0 mult=1 m=1
.ends
.GLOBAL vss
.end
