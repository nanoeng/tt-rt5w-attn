* from skywater-pdk-libs-sky130_fd_sc_hvl 4fd4f85 (CDL schematic), for simulation
.SUBCKT sky130_fd_sc_hvl__lsbuflv2hv_1 A LVPWR VGND VNB VPB VPWR X
XMI18 net81 cross1 VPWR VPB sky130_fd_pr__pfet_g5v0d10v5 W=0.42 L=1.0 m=1
XMI7 Abb Ab LVPWR LVPWR sky130_fd_pr__pfet_01v8_hvt W=0.84 L=0.15 m=1
XMI30 net65 cross1 VPWR VPB sky130_fd_pr__pfet_g5v0d10v5 W=1.5 L=0.5 m=1
XMI15 X net65 VPWR VPB sky130_fd_pr__pfet_g5v0d10v5 W=1.5 L=0.5 m=1
XMI19 cross1 net81 VPWR VPB sky130_fd_pr__pfet_g5v0d10v5 W=0.42 L=1.0 m=1
XMI27 Ab A LVPWR LVPWR sky130_fd_pr__pfet_01v8_hvt W=0.84 L=0.15 m=1
XMI8 Abb Ab VGND VNB sky130_fd_pr__nfet_01v8 W=0.84 L=0.15 m=1
XMI16 X net65 VGND VNB sky130_fd_pr__nfet_g5v0d10v5 W=0.75 L=0.5 m=1
XMI21 net81 Abb VGND VNB sky130_fd_pr__nfet_g5v0d10v5 W=1.5 L=0.5 m=5
XMI22 cross1 Ab VGND VNB sky130_fd_pr__nfet_g5v0d10v5 W=1.5 L=0.5 m=5
XMI28 Ab A VGND VNB sky130_fd_pr__nfet_01v8 W=0.84 L=0.15 m=1
XMI29 net65 cross1 VGND VNB sky130_fd_pr__nfet_g5v0d10v5 W=0.75 L=0.5 m=1
.ENDS sky130_fd_sc_hvl__lsbuflv2hv_1
