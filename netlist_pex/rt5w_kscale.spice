.subckt rt5w_kscale row k0 k1 k2 k3 g vdd vss
Xp g row k0 k1 k2 k3 vdd vss rt5w_kscale__pex
.ends

.subckt rt5w_kscale__pex g row k0 k1 k2 k3 vdd vss
X0 m1_306_n7546# k0 m1_4712_n4607# vss sky130_fd_pr__nfet_g5v0d10v5 ad=0.1218 pd=1.42 as=0.1218 ps=1.42 w=0.42 l=1
X1 vss row m1_8810_n4607# vss sky130_fd_pr__nfet_g5v0d10v5 ad=0.7163 pd=5.23 as=1.4326 ps=10.46 w=4.94 l=2
X2 m1_9062_n4607# row vss vss sky130_fd_pr__nfet_g5v0d10v5 ad=1.4326 pd=10.46 as=0.7163 ps=5.23 w=4.94 l=2
X3 vss row m1_8042_n4607# vss sky130_fd_pr__nfet_g5v0d10v5 ad=21.489 pd=156.9 as=1.5544 ps=11.88 w=4.94 l=2
X4 m1_8294_n4607# row vss vss sky130_fd_pr__nfet_g5v0d10v5 ad=1.5544 pd=11.88 as=0 ps=0 w=4.94 l=2
X5 vdd m1_306_n7546# g vdd sky130_fd_pr__pfet_g5v0d10v5 ad=0.7163 pd=5.23 as=0.7163 ps=5.23 w=4.94 l=2
X6 g m1_306_n7546# vdd vdd sky130_fd_pr__pfet_g5v0d10v5 ad=0.7163 pd=5.23 as=0.7163 ps=5.23 w=4.94 l=2
X7 m1_306_n7546# m1_306_n7546# vdd vdd sky130_fd_pr__pfet_g5v0d10v5 ad=0.7163 pd=5.23 as=0.7163 ps=5.23 w=4.94 l=2
X8 vdd m1_306_n7546# g vdd sky130_fd_pr__pfet_g5v0d10v5 ad=0.7163 pd=5.23 as=0.7163 ps=5.23 w=4.94 l=2
X9 m1_306_n7546# m1_306_n7546# vdd vdd sky130_fd_pr__pfet_g5v0d10v5 ad=0.7163 pd=5.23 as=0.7163 ps=5.23 w=4.94 l=2
X10 g m1_306_n7546# vdd vdd sky130_fd_pr__pfet_g5v0d10v5 ad=0.7163 pd=5.23 as=0.7163 ps=5.23 w=4.94 l=2
X11 vdd m1_306_n7546# m1_306_n7546# vdd sky130_fd_pr__pfet_g5v0d10v5 ad=0.7163 pd=5.23 as=0.7163 ps=5.23 w=4.94 l=2
X12 m1_306_n7546# m1_306_n7546# vdd vdd sky130_fd_pr__pfet_g5v0d10v5 ad=0.7163 pd=5.23 as=0.7163 ps=5.23 w=4.94 l=2
X13 g m1_306_n7546# vdd vdd sky130_fd_pr__pfet_g5v0d10v5 ad=0.7163 pd=5.23 as=0.7163 ps=5.23 w=4.94 l=2
X14 vdd m1_306_n7546# m1_306_n7546# vdd sky130_fd_pr__pfet_g5v0d10v5 ad=1.4326 pd=10.46 as=0.7163 ps=5.23 w=4.94 l=2
X15 vdd m1_306_n7546# g vdd sky130_fd_pr__pfet_g5v0d10v5 ad=0.7163 pd=5.23 as=1.4326 ps=10.46 w=4.94 l=2
X16 g m1_306_n7546# vdd vdd sky130_fd_pr__pfet_g5v0d10v5 ad=0.7163 pd=5.23 as=0.7163 ps=5.23 w=4.94 l=2
X17 g m1_306_n7546# vdd vdd sky130_fd_pr__pfet_g5v0d10v5 ad=0.7163 pd=5.23 as=0.7163 ps=5.23 w=4.94 l=2
X18 vdd m1_306_n7546# g vdd sky130_fd_pr__pfet_g5v0d10v5 ad=0.7163 pd=5.23 as=0.7163 ps=5.23 w=4.94 l=2
X19 vdd m1_306_n7546# g vdd sky130_fd_pr__pfet_g5v0d10v5 ad=0.7163 pd=5.23 as=0.7163 ps=5.23 w=4.94 l=2
X20 g m1_306_n7546# vdd vdd sky130_fd_pr__pfet_g5v0d10v5 ad=0.7163 pd=5.23 as=0.7163 ps=5.23 w=4.94 l=2
X21 vdd m1_306_n7546# g vdd sky130_fd_pr__pfet_g5v0d10v5 ad=0.7163 pd=5.23 as=0.7163 ps=5.23 w=4.94 l=2
X22 vdd m1_306_n7546# m1_306_n7546# vdd sky130_fd_pr__pfet_g5v0d10v5 ad=0.7163 pd=5.23 as=0.7163 ps=5.23 w=4.94 l=2
X23 g m1_306_n7546# vdd vdd sky130_fd_pr__pfet_g5v0d10v5 ad=0.7163 pd=5.23 as=0.7163 ps=5.23 w=4.94 l=2
X24 vdd m1_306_n7546# g vdd sky130_fd_pr__pfet_g5v0d10v5 ad=0.7163 pd=5.23 as=0.7163 ps=5.23 w=4.94 l=2
X25 vdd m1_306_n7546# g vdd sky130_fd_pr__pfet_g5v0d10v5 ad=0.7163 pd=5.23 as=0.7163 ps=5.23 w=4.94 l=2
X26 vss row m1_5222_n4607# vss sky130_fd_pr__nfet_g5v0d10v5 ad=0 pd=0 as=1.5544 ps=11.88 w=4.94 l=2
X27 m1_7526_n4607# row vss vss sky130_fd_pr__nfet_g5v0d10v5 ad=1.5544 pd=11.88 as=0 ps=0 w=4.94 l=2
X28 m1_306_n7546# k3 m1_3544_n5059# vss sky130_fd_pr__nfet_g5v0d10v5 ad=0.0609 pd=0.71 as=0.1218 ps=1.42 w=0.42 l=1
X29 m1_4460_n5059# k3 m1_306_n7546# vss sky130_fd_pr__nfet_g5v0d10v5 ad=0.1218 pd=1.42 as=0.0609 ps=0.71 w=0.42 l=1
X30 m1_306_n7546# k3 m1_9062_n4607# vss sky130_fd_pr__nfet_g5v0d10v5 ad=0.9744 pd=11.36 as=1.5544 ps=11.88 w=0.42 l=1
X31 m1_3292_n5059# k3 m1_306_n7546# vss sky130_fd_pr__nfet_g5v0d10v5 ad=1.5544 pd=11.88 as=0 ps=0 w=0.42 l=1
X32 m1_306_n7546# k3 m1_8294_n4607# vss sky130_fd_pr__nfet_g5v0d10v5 ad=0 pd=0 as=0 ps=0 w=0.42 l=1
X33 m1_8810_n4607# k3 m1_306_n7546# vss sky130_fd_pr__nfet_g5v0d10v5 ad=1.5544 pd=11.88 as=0 ps=0 w=0.42 l=1
X34 row row vss vss sky130_fd_pr__nfet_g5v0d10v5 ad=0.7163 pd=5.23 as=0.7163 ps=5.23 w=4.94 l=2
X35 row row vss vss sky130_fd_pr__nfet_g5v0d10v5 ad=0.7163 pd=5.23 as=0.7163 ps=5.23 w=4.94 l=2
X36 vss row row vss sky130_fd_pr__nfet_g5v0d10v5 ad=0.7163 pd=5.23 as=0.7163 ps=5.23 w=4.94 l=2
X37 vss row row vss sky130_fd_pr__nfet_g5v0d10v5 ad=0.7163 pd=5.23 as=0.7163 ps=5.23 w=4.94 l=2
X38 row row vss vss sky130_fd_pr__nfet_g5v0d10v5 ad=0.7163 pd=5.23 as=0.7163 ps=5.23 w=4.94 l=2
X39 vss row row vss sky130_fd_pr__nfet_g5v0d10v5 ad=0.7163 pd=5.23 as=0.7163 ps=5.23 w=4.94 l=2
X40 row row vss vss sky130_fd_pr__nfet_g5v0d10v5 ad=0.7163 pd=5.23 as=0.7163 ps=5.23 w=4.94 l=2
X41 m1_4712_n4607# row vss vss sky130_fd_pr__nfet_g5v0d10v5 ad=1.4326 pd=10.46 as=0.7163 ps=5.23 w=4.94 l=2
X42 vss row row vss sky130_fd_pr__nfet_g5v0d10v5 ad=0.7163 pd=5.23 as=0.7163 ps=5.23 w=4.94 l=2
X43 row row vss vss sky130_fd_pr__nfet_g5v0d10v5 ad=0.7163 pd=5.23 as=0.7163 ps=5.23 w=4.94 l=2
X44 row row vss vss sky130_fd_pr__nfet_g5v0d10v5 ad=0.7163 pd=5.23 as=0.7163 ps=5.23 w=4.94 l=2
X45 vss row row vss sky130_fd_pr__nfet_g5v0d10v5 ad=0.7163 pd=5.23 as=0.7163 ps=5.23 w=4.94 l=2
X46 vss row row vss sky130_fd_pr__nfet_g5v0d10v5 ad=0.7163 pd=5.23 as=1.4326 ps=10.46 w=4.94 l=2
X47 vss row row vss sky130_fd_pr__nfet_g5v0d10v5 ad=0.7163 pd=5.23 as=0.7163 ps=5.23 w=4.94 l=2
X48 vss row row vss sky130_fd_pr__nfet_g5v0d10v5 ad=0.7163 pd=5.23 as=0.7163 ps=5.23 w=4.94 l=2
X49 row row vss vss sky130_fd_pr__nfet_g5v0d10v5 ad=0.7163 pd=5.23 as=0.7163 ps=5.23 w=4.94 l=2
X50 m1_306_n7546# k3 m1_7526_n4607# vss sky130_fd_pr__nfet_g5v0d10v5 ad=0 pd=0 as=0 ps=0 w=0.42 l=1
X51 m1_8042_n4607# k3 m1_306_n7546# vss sky130_fd_pr__nfet_g5v0d10v5 ad=0 pd=0 as=0 ps=0 w=0.42 l=1
X52 m1_306_n7546# k2 m1_2124_n5059# vss sky130_fd_pr__nfet_g5v0d10v5 ad=0 pd=0 as=1.5544 ps=11.88 w=0.42 l=1
X53 m1_2376_n5059# k2 m1_306_n7546# vss sky130_fd_pr__nfet_g5v0d10v5 ad=1.5544 pd=11.88 as=0 ps=0 w=0.42 l=1
X54 vdd m1_306_n7546# m1_306_n7546# vdd sky130_fd_pr__pfet_g5v0d10v5 ad=0.7163 pd=5.23 as=0.7163 ps=5.23 w=4.94 l=2
X55 m1_306_n7546# m1_306_n7546# vdd vdd sky130_fd_pr__pfet_g5v0d10v5 ad=0.7163 pd=5.23 as=0.7163 ps=5.23 w=4.94 l=2
X56 m1_306_n7546# m1_306_n7546# vdd vdd sky130_fd_pr__pfet_g5v0d10v5 ad=0.7163 pd=5.23 as=0.7163 ps=5.23 w=4.94 l=2
X57 m1_306_n7546# m1_306_n7546# vdd vdd sky130_fd_pr__pfet_g5v0d10v5 ad=1.4326 pd=10.46 as=0.7163 ps=5.23 w=4.94 l=2
X58 m1_306_n7546# m1_306_n7546# vdd vdd sky130_fd_pr__pfet_g5v0d10v5 ad=0.7163 pd=5.23 as=0.7163 ps=5.23 w=4.94 l=2
X59 vdd m1_306_n7546# m1_306_n7546# vdd sky130_fd_pr__pfet_g5v0d10v5 ad=0.7163 pd=5.23 as=0.7163 ps=5.23 w=4.94 l=2
X60 vdd m1_306_n7546# m1_306_n7546# vdd sky130_fd_pr__pfet_g5v0d10v5 ad=0.7163 pd=5.23 as=0.7163 ps=5.23 w=4.94 l=2
X61 vdd m1_306_n7546# m1_306_n7546# vdd sky130_fd_pr__pfet_g5v0d10v5 ad=0.7163 pd=5.23 as=0.7163 ps=5.23 w=4.94 l=2
X62 m1_306_n7546# m1_306_n7546# vdd vdd sky130_fd_pr__pfet_g5v0d10v5 ad=0.7163 pd=5.23 as=1.4326 ps=10.46 w=4.94 l=2
X63 m1_306_n7546# k2 m1_956_n5059# vss sky130_fd_pr__nfet_g5v0d10v5 ad=0 pd=0 as=1.5544 ps=11.88 w=0.42 l=1
X64 m1_1208_n5059# k2 m1_306_n7546# vss sky130_fd_pr__nfet_g5v0d10v5 ad=1.5544 pd=11.88 as=0 ps=0 w=0.42 l=1
X65 m1_306_n7546# k1 m1_5222_n4607# vss sky130_fd_pr__nfet_g5v0d10v5 ad=0 pd=0 as=0 ps=0 w=0.42 l=1
X66 m1_40_n5059# k1 m1_306_n7546# vss sky130_fd_pr__nfet_g5v0d10v5 ad=1.5544 pd=11.88 as=0 ps=0 w=0.42 l=1
X67 m1_4460_n5059# row vss vss sky130_fd_pr__nfet_g5v0d10v5 ad=1.4326 pd=10.46 as=0.7163 ps=5.23 w=4.94 l=2
X68 vss row m1_3544_n5059# vss sky130_fd_pr__nfet_g5v0d10v5 ad=0.7163 pd=5.23 as=1.4326 ps=10.46 w=4.94 l=2
X69 m1_3292_n5059# row vss vss sky130_fd_pr__nfet_g5v0d10v5 ad=0 pd=0 as=0 ps=0 w=4.94 l=2
X70 vss row m1_2376_n5059# vss sky130_fd_pr__nfet_g5v0d10v5 ad=0 pd=0 as=0 ps=0 w=4.94 l=2
X71 m1_2124_n5059# row vss vss sky130_fd_pr__nfet_g5v0d10v5 ad=0 pd=0 as=0 ps=0 w=4.94 l=2
X72 vss row m1_1208_n5059# vss sky130_fd_pr__nfet_g5v0d10v5 ad=0 pd=0 as=0 ps=0 w=4.94 l=2
X73 m1_956_n5059# row vss vss sky130_fd_pr__nfet_g5v0d10v5 ad=0 pd=0 as=0 ps=0 w=4.94 l=2
X74 vss row m1_40_n5059# vss sky130_fd_pr__nfet_g5v0d10v5 ad=0 pd=0 as=0 ps=0 w=4.94 l=2
C0 m1_5222_n4607# m1_3292_n5059# 1.54e-19
C1 vdd m1_956_n5059# 0.005679f
C2 m1_4712_n4607# m1_2376_n5059# 0.053693f
C3 m1_7526_n4607# m1_8042_n4607# 1.45217f
C4 row m1_7526_n4607# 0.606199f
C5 m1_306_n7546# m1_4460_n5059# 0.26553f
C6 m1_5222_n4607# vdd 0.004236f
C7 m1_8810_n4607# m1_4712_n4607# 3.68e-19
C8 m1_306_n7546# m1_2124_n5059# 0.693799f
C9 k0 m1_2376_n5059# 0.043909f
C10 m1_3292_n5059# k2 0.036307f
C11 m1_40_n5059# k1 3.092667f
C12 m1_306_n7546# m1_8294_n4607# 0.165976f
C13 k2 m1_9062_n4607# 0.102366f
C14 m1_7526_n4607# m1_306_n7546# 0.557227f
C15 m1_3544_n5059# k1 0.033393f
C16 m1_956_n5059# m1_4712_n4607# 0.044558f
C17 m1_3292_n5059# m1_8042_n4607# 0.015639f
C18 row m1_3292_n5059# 0.430674f
C19 m1_40_n5059# m1_3544_n5059# 0.033342f
C20 k3 m1_1208_n5059# 5.41e-20
C21 m1_5222_n4607# m1_4712_n4607# 1.032068f
C22 k0 m1_956_n5059# 0.044263f
C23 vdd m1_8042_n4607# 0.002725f
C24 row vdd 0.460313f
C25 m1_9062_n4607# m1_8042_n4607# 0.047174f
C26 row m1_9062_n4607# 0.442795f
C27 m1_5222_n4607# k0 0.013023f
C28 k2 m1_4712_n4607# 0.446082f
C29 m1_306_n7546# m1_3292_n5059# 0.396386f
C30 k1 m1_4460_n5059# 0.034825f
C31 m1_2124_n5059# k1 0.033508f
C32 m1_40_n5059# m1_4460_n5059# 0.037805f
C33 k3 m1_2376_n5059# 0.052271f
C34 m1_40_n5059# m1_2124_n5059# 0.033514f
C35 m1_306_n7546# vdd 21.738731f
C36 m1_306_n7546# m1_9062_n4607# 0.071598f
C37 k3 m1_8810_n4607# 1.520567f
C38 m1_8042_n4607# m1_4712_n4607# 0.013389f
C39 row m1_4712_n4607# 0.651425f
C40 m1_3544_n5059# m1_4460_n5059# 2.694364f
C41 m1_1208_n5059# m1_2376_n5059# 0.037965f
C42 row k0 1.007235f
C43 m1_3544_n5059# m1_2124_n5059# 0.035943f
C44 m1_3544_n5059# m1_8294_n4607# 0.045048f
C45 k3 m1_956_n5059# 0.002909f
C46 m1_306_n7546# m1_4712_n4607# 2.153349f
C47 m1_5222_n4607# k3 0.141804f
C48 m1_7526_n4607# m1_3544_n5059# 2.8e-19
C49 m1_306_n7546# k0 0.407913f
C50 m1_1208_n5059# m1_956_n5059# 2.853864f
C51 m1_3292_n5059# k1 0.033417f
C52 m1_2124_n5059# m1_4460_n5059# 0.039638f
C53 m1_8810_n4607# m1_2376_n5059# 0.004415f
C54 m1_40_n5059# m1_3292_n5059# 0.033362f
C55 m1_5222_n4607# m1_1208_n5059# 0.038086f
C56 k3 k2 0.557484f
C57 m1_8294_n4607# m1_4460_n5059# 0.028502f
C58 vdd k1 0.161343f
C59 m1_40_n5059# vdd 0.062328f
C60 m1_7526_n4607# m1_4460_n5059# 1.88e-19
C61 row g 3.582705f
C62 m1_3292_n5059# m1_3544_n5059# 3.965481f
C63 k2 m1_1208_n5059# 0.40713f
C64 row k3 0.016611f
C65 k3 m1_8042_n4607# 0.684097f
C66 m1_956_n5059# m1_2376_n5059# 0.037155f
C67 m1_7526_n4607# m1_2124_n5059# 1.23e-19
C68 m1_3544_n5059# vdd 0.006605f
C69 m1_5222_n4607# m1_2376_n5059# 0.038041f
C70 m1_7526_n4607# m1_8294_n4607# 0.066983f
C71 m1_9062_n4607# m1_3544_n5059# 0.086024f
C72 m1_5222_n4607# m1_8810_n4607# 0.003251f
C73 row m1_1208_n5059# 0.427258f
C74 k1 m1_4712_n4607# 0.036362f
C75 m1_40_n5059# m1_4712_n4607# 0.556381f
C76 m1_306_n7546# g 6.206792f
C77 k2 m1_2376_n5059# 0.40625f
C78 m1_3292_n5059# m1_4460_n5059# 0.04053f
C79 k0 k1 2.633422f
C80 m1_306_n7546# k3 5.494945f
C81 m1_3292_n5059# m1_2124_n5059# 0.037839f
C82 m1_40_n5059# k0 0.048094f
C83 m1_8810_n4607# k2 0.099926f
C84 m1_3544_n5059# m1_4712_n4607# 6.68e-19
C85 m1_5222_n4607# m1_956_n5059# 0.044141f
C86 m1_3292_n5059# m1_8294_n4607# 0.042283f
C87 m1_9062_n4607# m1_4460_n5059# 0.11687f
C88 vdd m1_2124_n5059# 1.84e-19
C89 m1_306_n7546# m1_1208_n5059# 0.949523f
C90 row m1_2376_n5059# 0.425066f
C91 k0 m1_3544_n5059# 0.043923f
C92 m1_7526_n4607# m1_3292_n5059# 4.18e-19
C93 m1_8810_n4607# m1_8042_n4607# 0.063421f
C94 row m1_8810_n4607# 0.524683f
C95 m1_9062_n4607# m1_8294_n4607# 0.070018f
C96 k2 m1_956_n5059# 0.374842f
C97 m1_7526_n4607# vdd 0.004236f
C98 m1_5222_n4607# k2 1.087347f
C99 m1_7526_n4607# m1_9062_n4607# 0.02717f
C100 m1_4460_n5059# m1_4712_n4607# 0.207437f
C101 m1_306_n7546# m1_2376_n5059# 0.703638f
C102 m1_2124_n5059# m1_4712_n4607# 0.043081f
C103 row m1_956_n5059# 0.432782f
C104 k0 m1_4460_n5059# 0.05932f
C105 m1_306_n7546# m1_8810_n4607# 0.084241f
C106 k0 m1_2124_n5059# 0.043928f
C107 m1_5222_n4607# m1_8042_n4607# 0.033212f
C108 row m1_5222_n4607# 0.5655f
C109 m1_3292_n5059# vdd 1.67e-19
C110 m1_7526_n4607# m1_4712_n4607# 0.134368f
C111 m1_3292_n5059# m1_9062_n4607# 0.214657f
C112 k2 m1_8042_n4607# 0.213604f
C113 m1_1208_n5059# k1 0.033759f
C114 row k2 0.013854f
C115 m1_306_n7546# m1_956_n5059# 3.237851f
C116 k3 m1_3544_n5059# 0.585666f
C117 m1_40_n5059# m1_1208_n5059# 0.033669f
C118 m1_5222_n4607# m1_306_n7546# 0.764906f
C119 row m1_8042_n4607# 0.561508f
C120 m1_3544_n5059# m1_1208_n5059# 0.035734f
C121 m1_3292_n5059# m1_4712_n4607# 6.38e-19
C122 m1_306_n7546# k2 1.795156f
C123 k1 m1_2376_n5059# 0.033453f
C124 m1_40_n5059# m1_2376_n5059# 0.033423f
C125 m1_3292_n5059# k0 0.043921f
C126 k3 m1_4460_n5059# 0.595239f
C127 vdd m1_4712_n4607# 0.002716f
C128 m1_9062_n4607# m1_4712_n4607# 8.93e-20
C129 k3 m1_2124_n5059# 8.97e-20
C130 k0 vdd 0.161292f
C131 row m1_306_n7546# 14.50272f
C132 m1_306_n7546# m1_8042_n4607# 1.25597f
C133 k3 m1_8294_n4607# 0.616518f
C134 m1_3544_n5059# m1_2376_n5059# 0.036512f
C135 m1_1208_n5059# m1_4460_n5059# 0.039545f
C136 m1_1208_n5059# m1_2124_n5059# 2.513931f
C137 m1_8810_n4607# m1_3544_n5059# 0.038645f
C138 k1 m1_956_n5059# 0.03544f
C139 m1_7526_n4607# k3 0.5838f
C140 m1_40_n5059# m1_956_n5059# 0.294424f
C141 m1_5222_n4607# k1 0.624237f
C142 m1_40_n5059# m1_5222_n4607# 0.076318f
C143 k0 m1_4712_n4607# 0.364627f
C144 m1_7526_n4607# m1_1208_n5059# 6.9e-20
C145 m1_4460_n5059# m1_2376_n5059# 0.039845f
C146 m1_3544_n5059# m1_956_n5059# 0.035508f
C147 k2 k1 0.023989f
C148 m1_2124_n5059# m1_2376_n5059# 2.740725f
C149 m1_8810_n4607# m1_4460_n5059# 0.067477f
C150 m1_5222_n4607# m1_3544_n5059# 1.24e-19
C151 m1_40_n5059# k2 0.001166f
C152 k3 m1_3292_n5059# 0.73796f
C153 vdd g 2.906854f
C154 m1_8810_n4607# m1_8294_n4607# 1.491637f
C155 row k1 0.369872f
C156 k3 m1_9062_n4607# 0.88637f
C157 k2 m1_3544_n5059# 0.036262f
C158 m1_7526_n4607# m1_2376_n5059# 0.255922f
C159 m1_3292_n5059# m1_1208_n5059# 0.037267f
C160 m1_40_n5059# row 2.635427f
C161 m1_956_n5059# m1_4460_n5059# 0.043828f
C162 m1_7526_n4607# m1_8810_n4607# 0.051365f
C163 m1_2124_n5059# m1_956_n5059# 0.036522f
C164 vdd m1_1208_n5059# 0.004321f
C165 m1_5222_n4607# m1_4460_n5059# 5.44e-19
C166 m1_5222_n4607# m1_2124_n5059# 0.038055f
C167 m1_3544_n5059# m1_8042_n4607# 0.009234f
C168 row m1_3544_n5059# 0.424293f
C169 g m1_4712_n4607# 0.005706f
C170 m1_306_n7546# k1 0.909528f
C171 m1_5222_n4607# m1_8294_n4607# 0.028583f
C172 k3 m1_4712_n4607# 0.04451f
C173 m1_40_n5059# m1_306_n7546# 0.336705f
C174 m1_7526_n4607# m1_956_n5059# 3e-20
C175 m1_3292_n5059# m1_2376_n5059# 2.002584f
C176 k2 m1_4460_n5059# 0.048623f
C177 k2 m1_2124_n5059# 0.40688f
C178 m1_8810_n4607# m1_3292_n5059# 0.081624f
C179 m1_5222_n4607# m1_7526_n4607# 0.41506f
C180 vdd m1_2376_n5059# 0.001908f
C181 k2 m1_8294_n4607# 0.982337f
C182 m1_1208_n5059# m1_4712_n4607# 0.041628f
C183 m1_306_n7546# m1_3544_n5059# 0.471276f
C184 m1_8042_n4607# m1_4460_n5059# 0.001135f
C185 row m1_4460_n5059# 0.385963f
C186 m1_8810_n4607# m1_9062_n4607# 1.547068f
C187 k0 m1_1208_n5059# 0.044039f
C188 row m1_2124_n5059# 0.423219f
C189 m1_7526_n4607# k2 0.774781f
C190 m1_3292_n5059# m1_956_n5059# 0.0369f
C191 m1_8294_n4607# m1_8042_n4607# 0.641907f
C192 row m1_8294_n4607# 0.649032f
C193 m1_956_n5059# vss 1.080966f $ **FLOATING
C194 m1_40_n5059# vss 1.307757f $ **FLOATING
C195 row vss 43.98299f
C196 m1_2124_n5059# vss 0.990765f $ **FLOATING
C197 m1_1208_n5059# vss 1.236689f $ **FLOATING
C198 m1_3292_n5059# vss 1.260008f $ **FLOATING
C199 m1_2376_n5059# vss 1.143208f $ **FLOATING
C200 m1_4460_n5059# vss 2.895305f $ **FLOATING
C201 m1_3544_n5059# vss 1.350984f $ **FLOATING
C202 m1_5222_n4607# vss 1.532394f $ **FLOATING
C203 k1 vss 1.530759f
C204 k2 vss 2.557672f
C205 m1_306_n7546# vss 26.871996f $ **FLOATING
C206 vdd vss 54.07405f
C207 m1_8042_n4607# vss 1.393567f $ **FLOATING
C208 m1_7526_n4607# vss 1.370891f $ **FLOATING
C209 k3 vss 5.390682f
C210 m1_8810_n4607# vss 1.438987f $ **FLOATING
C211 m1_8294_n4607# vss 1.55158f $ **FLOATING
C212 m1_9062_n4607# vss 2.807835f $ **FLOATING
C213 g vss 3.247694f
C214 m1_4712_n4607# vss 1.351071f $ **FLOATING
C215 k0 vss 1.561347f
.ends
